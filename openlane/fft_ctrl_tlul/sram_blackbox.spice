* @generated — vyges-soc-generator  DO NOT EDIT
* Blackbox stub for CF_SRAM_1024x32 (ChipFoundry commercial SRAM)
* Pin-level only — no internal devices. For LVS blackbox verification.
* Pin names use bus notation to match Netgen extraction from GDS.
.subckt CF_SRAM_1024x32
+ CLKin EN R_WB ScanInCC ScanInDL ScanInDR ScanOutCC SM TM WLBI WLOFF
+ AD[0] AD[1] AD[2] AD[3] AD[4] AD[5] AD[6] AD[7] AD[8] AD[9]
+ DI[0] DI[1] DI[2] DI[3] DI[4] DI[5] DI[6] DI[7]
+ DI[8] DI[9] DI[10] DI[11] DI[12] DI[13] DI[14] DI[15]
+ DI[16] DI[17] DI[18] DI[19] DI[20] DI[21] DI[22] DI[23]
+ DI[24] DI[25] DI[26] DI[27] DI[28] DI[29] DI[30] DI[31]
+ BEN[0] BEN[1] BEN[2] BEN[3] BEN[4] BEN[5] BEN[6] BEN[7]
+ BEN[8] BEN[9] BEN[10] BEN[11] BEN[12] BEN[13] BEN[14] BEN[15]
+ BEN[16] BEN[17] BEN[18] BEN[19] BEN[20] BEN[21] BEN[22] BEN[23]
+ BEN[24] BEN[25] BEN[26] BEN[27] BEN[28] BEN[29] BEN[30] BEN[31]
+ DO[0] DO[1] DO[2] DO[3] DO[4] DO[5] DO[6] DO[7]
+ DO[8] DO[9] DO[10] DO[11] DO[12] DO[13] DO[14] DO[15]
+ DO[16] DO[17] DO[18] DO[19] DO[20] DO[21] DO[22] DO[23]
+ DO[24] DO[25] DO[26] DO[27] DO[28] DO[29] DO[30] DO[31]
+ vpwra vpwrp vpwrm vpwrac vpwrpc vgnd vpb vnb
.ends
